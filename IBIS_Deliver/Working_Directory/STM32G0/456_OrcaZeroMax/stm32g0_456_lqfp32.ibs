| IBIS file stm32g0_456_lqfp32.ibs
| Created by s2ibis version 1.1 (customized version)
| North Carolina State University, ERL, 2006
[IBIS ver] 4.2
[File name] stm32g0_456_lqfp32.ibs
[File Rev] 1.0
[Date]  28-06-2021
[Source] Data Created at STMicroelectronics
[Notes]  File originated from ELDO simulations.
[Disclaimer]  This information is for modeling purpose only and is
   not guaranted. The information is subject to change without
   notice.
[Copyright] Copyright 2013 STMicroelectronics Inc.
|   Component stm32g0_456_lqfp32
[Component] stm32g0_456_lqfp32
[Manufacturer] STMicroelectronics
[Package]
| variable   typ   min   max
R_pkg   0.0   0.0   0.0
L_pkg   0.0H   0.0H   0.0H
C_pkg   0.0F   0.0F   0.0F
[Pin]   signal_name   model_name  R_pin L_pin C_pin
1 PB9 io6_i2c_ft 64.896E-3 2.0240E-9 16.235E-15
2 PC14-OSC32_IN io8_ft 54.988E-3 1.7405E-9 14.587E-15
3 PC15-OSC32_OUT io8_ft 53.017E-3 1.6595E-9 8.197E-15
4 VBAT POWER 54.033E-3 1.6554E-9 7.363E-15
5 VSS GND 56.223E-3 1.7156E-9 10.783E-15
6 PF2-NRST io6reset 61.160E-3 1.8629E-9 10.243E-15
7 PA0 io6_ft 59.987E-3 1.8648E-9 10.852E-15
8 PA1 io6_ft 71.192E-3 2.1932E-9 17.019E-15
9 PA2 io6_ft 71.059E-3 2.1776E-9 16.855E-15
10 PA3 io6_ft 63.005E-3 1.9478E-9 14.439E-15
11 PA4 io6_ft 58.243E-3 1.7981E-9 7.948E-15
12 PA5 io6_ft 55.874E-3 1.7092E-9 8.812E-15
13 PA6 io6_ft 55.141E-3 1.6964E-9 12.212E-15
14 PA7 io6_ft 56.661E-3 1.7554E-9 4.706E-15
15 PB0 io6_ft 61.182E-3 1.8979E-9 13.557E-15
16 PB1 io6_ft 68.639E-3 2.1172E-9 16.500E-15
17 PB2 io6_ft 66.539E-3 2.0692E-9 17.677E-15
18 PA8 io6_ft 71.158E-3 2.1438E-9 11.062E-15
19 PA9 io6_i2c_ft 63.842E-3 1.9327E-9 9.196E-15
20 PC6 io6_ft 58.291E-3 1.7635E-9 11.677E-15
21 PA10 io6_i2c_ft 54.700E-3 1.6700E-9 6.891E-15
22 PA11 io6_i2c_ft 53.046E-3 1.6525E-9 10.905E-15
23 PA12 io6_i2c_ft 62.866E-3 1.9450E-9 11.111E-15
24 PA13 io6_ft 75.711E-3 2.3060E-9 17.278E-15
25 PA14-BOOT0 io6_ft 74.224E-3 2.2583E-9 19.736E-15
26 PA15 io6_ft 65.224E-3 2.0006E-9 8.439E-15
27 PB3 io6_ft 59.281E-3 1.8183E-9 10.281E-15
28 PB4 io6_ft 56.029E-3 1.7169E-9 8.461E-15
29 PB5 io6_ft 55.139E-3 1.6969E-9 12.383E-15
30 PB6 io6_i2c_ft 56.372E-3 1.7463E-9 4.202E-15
31 PB7 io6_i2c_ft 59.845E-3 1.8672E-9 13.676E-15
32 PB8 io6_i2c_ft 66.777E-3 2.0705E-9 14.725E-15
[Model Selector] io6_ft
io6_ft_1v8_highspeed_pd  "GPIO-1.8V range - high speed - pull down"
io6_ft_1v8_fastspeed_pd  "GPIO-1.8V range - fast speed - pull down"
io6_ft_1v8_mediumspeed_pd  "GPIO-1.8V range - medium speed - pull down"
io6_ft_1v8_lowspeed_pd  "GPIO-1.8V range - low speed - pull down"
io6_ft_1v8_highspeed_pu  "GPIO-1.8V range - high speed - pull up"
io6_ft_1v8_fastspeed_pu  "GPIO-1.8V range - fast speed - pull up"
io6_ft_1v8_mediumspeed_pu  "GPIO-1.8V range - medium speed - pull up"
io6_ft_1v8_lowspeed_pu  "GPIO-1.8V range - low speed - pull up"
io6_ft_1v8_highspeed  "GPIO-1.8V range - high speed"
io6_ft_1v8_fastspeed  "GPIO-1.8V range - fast speed"
io6_ft_1v8_mediumspeed  "GPIO-1.8V range - medium speed"
io6_ft_1v8_lowspeed  "GPIO-1.8V range - low speed"
io6_ft_3v3_highspeed_pd  "GPIO-3.3V range - high speed - pull down"
io6_ft_3v3_fastspeed_pd  "GPIO-3.3V range - fast speed - pull down"
io6_ft_3v3_mediumspeed_pd  "GPIO-3.3V range - medium speed - pull down"
io6_ft_3v3_lowspeed_pd  "GPIO-3.3V range - low speed - pull down"
io6_ft_3v3_highspeed_pu  "GPIO-3.3V range - high speed - pull up"
io6_ft_3v3_fastspeed_pu  "GPIO-3.3V range - fast speed - pull up"
io6_ft_3v3_mediumspeed_pu  "GPIO-3.3V range - medium speed - pull up"
io6_ft_3v3_lowspeed_pu  "GPIO-3.3V range - low speed - pull up"
io6_ft_3v3_highspeed  "GPIO-3.3V range - high speed"
io6_ft_3v3_fastspeed  "GPIO-3.3V range - fast speed"
io6_ft_3v3_mediumspeed  "GPIO-3.3V range - medium speed"
io6_ft_3v3_lowspeed  "GPIO-3.3V range - low speed"
[Model Selector] io6_i2c_ft
io6_ft_1v8_highspeed_pd  "GPIO-1.8V range - high speed - pull down"
io6_ft_1v8_fastspeed_pd  "GPIO-1.8V range - fast speed - pull down"
io6_ft_1v8_mediumspeed_pd  "GPIO-1.8V range - medium speed - pull down"
io6_ft_1v8_lowspeed_pd  "GPIO-1.8V range - low speed - pull down"
io6_ft_1v8_highspeed_pu  "GPIO-1.8V range - high speed - pull up"
io6_ft_1v8_fastspeed_pu  "GPIO-1.8V range - fast speed - pull up"
io6_ft_1v8_mediumspeed_pu  "GPIO-1.8V range - medium speed - pull up"
io6_ft_1v8_lowspeed_pu  "GPIO-1.8V range - low speed - pull up"
io6_ft_1v8_highspeed  "GPIO-1.8V range - high speed"
io6_ft_1v8_fastspeed  "GPIO-1.8V range - fast speed"
io6_ft_1v8_mediumspeed  "GPIO-1.8V range - medium speed"
io6_ft_1v8_lowspeed  "GPIO-1.8V range - low speed"
io6_ft_3v3_highspeed_pd  "GPIO-3.3V range - high speed - pull down"
io6_ft_3v3_fastspeed_pd  "GPIO-3.3V range - fast speed - pull down"
io6_ft_3v3_mediumspeed_pd  "GPIO-3.3V range - medium speed - pull down"
io6_ft_3v3_lowspeed_pd  "GPIO-3.3V range - low speed - pull down"
io6_ft_3v3_highspeed_pu  "GPIO-3.3V range - high speed - pull up"
io6_ft_3v3_fastspeed_pu  "GPIO-3.3V range - fast speed - pull up"
io6_ft_3v3_mediumspeed_pu  "GPIO-3.3V range - medium speed - pull up"
io6_ft_3v3_lowspeed_pu  "GPIO-3.3V range - low speed - pull up"
io6_ft_3v3_highspeed  "GPIO-3.3V range - high speed"
io6_ft_3v3_fastspeed  "GPIO-3.3V range - fast speed"
io6_ft_3v3_mediumspeed  "GPIO-3.3V range - medium speed"
io6_ft_3v3_lowspeed  "GPIO-3.3V range - low speed"
io6_i2c_ft_1v8_pd  "GPIO-1.8V I2C functionality - pull down"
io6_i2c_ft_3v3_pd  "GPIO-3.3V I2C functionality - pull down"
io6_i2c_ft_1v8_pu  "GPIO-1.8V I2C functionality - pull up"
io6_i2c_ft_3v3_pu  "GPIO-3.3V I2C functionality pull up"
io6_i2c_ft_1v8  "GPIO-1.8V I2C functionality"
io6_i2c_ft_3v3  "GPIO-3.3V I2C functionality"
[Model Selector] io6reset
io6_ft_1v8_highspeed_pd  "GPIO-1.8V range - high speed - pull down"
io6_ft_1v8_fastspeed_pd  "GPIO-1.8V range - fast speed - pull down"
io6_ft_1v8_mediumspeed_pd  "GPIO-1.8V range - medium speed - pull down"
io6_ft_1v8_lowspeed_pd  "GPIO-1.8V range - low speed - pull down"
io6_ft_1v8_highspeed_pu  "GPIO-1.8V range - high speed - pull up"
io6_ft_1v8_fastspeed_pu  "GPIO-1.8V range - fast speed - pull up"
io6_ft_1v8_mediumspeed_pu  "GPIO-1.8V range - medium speed - pull up"
io6_ft_1v8_lowspeed_pu  "GPIO-1.8V range - low speed - pull up"
io6_ft_1v8_highspeed  "GPIO-1.8V range - high speed"
io6_ft_1v8_fastspeed  "GPIO-1.8V range - fast speed"
io6_ft_1v8_mediumspeed  "GPIO-1.8V range - medium speed"
io6_ft_1v8_lowspeed  "GPIO-1.8V range - low speed"
io6_ft_3v3_highspeed_pd  "GPIO-3.3V range - high speed - pull down"
io6_ft_3v3_fastspeed_pd  "GPIO-3.3V range - fast speed - pull down"
io6_ft_3v3_mediumspeed_pd  "GPIO-3.3V range - medium speed - pull down"
io6_ft_3v3_lowspeed_pd  "GPIO-3.3V range - low speed - pull down"
io6_ft_3v3_highspeed_pu  "GPIO-3.3V range - high speed - pull up"
io6_ft_3v3_fastspeed_pu  "GPIO-3.3V range - fast speed - pull up"
io6_ft_3v3_mediumspeed_pu  "GPIO-3.3V range - medium speed - pull up"
io6_ft_3v3_lowspeed_pu  "GPIO-3.3V range - low speed - pull up"
io6_ft_3v3_highspeed  "GPIO-3.3V range - high speed"
io6_ft_3v3_fastspeed  "GPIO-3.3V range - fast speed"
io6_ft_3v3_mediumspeed  "GPIO-3.3V range - medium speed"
io6_ft_3v3_lowspeed  "GPIO-3.3V range - low speed"
ioreset_1v2_pu  "RESET 1.2V range with PU"
ioreset_1v2  "RESET 1.2V range"
ioreset_1v8_pu  "RESET 1.8V range with PU"
ioreset_1v8  "RESET 1.8V range"
ioreset_3v3_pu  "RESET 3.3V range with PU"
ioreset_3v3  "RESET 3.3V range"
[Model Selector] io8_ft
io8_ft_ls_1v2   "GPIO - 5V tolerant - 1.2V range - Low speed"
io8_ft_ms_1v2   "GPIO - 5V tolerant - 1.2V range - Med speed"
io8_ft_fs_1v2   "GPIO - 5V tolerant - 1.2V range - Fast speed"
io8_ft_hs_1v2   "GPIO - 5V tolerant - 1.2V range - High speed"
io8_ft_ls_1v8   "GPIO - 5V tolerant - 1.8V range - Low speed"
io8_ft_ms_1v8   "GPIO - 5V tolerant - 1.8V range - Med speed"
io8_ft_fs_1v8   "GPIO - 5V tolerant - 1.8V range - Fast speed"
io8_ft_hs_1v8   "GPIO - 5V tolerant - 1.8V range - High speed"
io8_ft_ls_3v3   "GPIO - 5V tolerant - 3.3V range - Low speed"
io8_ft_ms_3v3   "GPIO - 5V tolerant - 3.3V range - Med speed"
io8_ft_fs_3v3   "GPIO - 5V tolerant - 3.3V range - Fast speed"
io8_ft_hs_3v3   "GPIO - 5V tolerant - 3.3V range - High speed"
| Models and submodels in the file (48): io6_ft_1v8_highspeed_pd (I/O), io6_ft_1v8_fastspeed_pd (I/O), io6_ft_1v8_mediumspeed_pd (I/O), io6_ft_1v8_lowspeed_pd (I/O), io6_ft_1v8_highspeed_pu (I/O), io6_ft_1v8_fastspeed_pu (I/O), io6_ft_1v8_mediumspeed_pu (I/O), io6_ft_1v8_lowspeed_pu (I/O), io6_ft_1v8_highspeed (I/O), io6_ft_1v8_fastspeed (I/O), io6_ft_1v8_mediumspeed (I/O), io6_ft_1v8_lowspeed (I/O), io6_ft_3v3_highspeed_pd (I/O), io6_ft_3v3_fastspeed_pd (I/O), io6_ft_3v3_mediumspeed_pd (I/O), io6_ft_3v3_lowspeed_pd (I/O), io6_ft_3v3_highspeed_pu (I/O), io6_ft_3v3_fastspeed_pu (I/O), io6_ft_3v3_mediumspeed_pu (I/O), io6_ft_3v3_lowspeed_pu (I/O), io6_ft_3v3_highspeed (I/O), io6_ft_3v3_fastspeed (I/O), io6_ft_3v3_mediumspeed (I/O), io6_ft_3v3_lowspeed (I/O), io6_i2c_ft_1v8_pd (I/O_open_drain), io6_i2c_ft_3v3_pd (I/O_open_drain), io6_i2c_ft_1v8_pu (I/O_open_drain), io6_i2c_ft_3v3_pu (I/O_open_drain), io6_i2c_ft_1v8 (I/O_open_drain), io6_i2c_ft_3v3 (I/O_open_drain), ioreset_1v2_pu (I/O_open_drain), ioreset_1v2 (I/O_open_drain), ioreset_1v8_pu (I/O_open_drain), ioreset_1v8 (I/O_open_drain), ioreset_3v3_pu (I/O_open_drain), ioreset_3v3 (I/O_open_drain), io8_ft_ls_1v2 (I/O), io8_ft_ms_1v2 (I/O), io8_ft_fs_1v2 (I/O), io8_ft_hs_1v2 (I/O), io8_ft_ls_1v8 (I/O), io8_ft_ms_1v8 (I/O), io8_ft_fs_1v8 (I/O), io8_ft_hs_1v8 (I/O), io8_ft_ls_3v3 (I/O), io8_ft_ms_3v3 (I/O), io8_ft_fs_3v3 (I/O), io8_ft_hs_3v3 (I/O)
